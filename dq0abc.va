module DQ0ABC(xa,xb,xc,xd,xq,x0,teta);
input  xd,xq,x0,teta;
output xa,xb,xc;

electrical xd,xq,x0,teta;
electrical xa,xb,xc;

parameter real GAIN = 1      alterable;
parameter real TETA_GAIN = 1 alterable;

analog begin

v(xa) <+ GAIN*(v(xd)*cos((2*pi*50*($abstime) + v(teta))*TETA_GAIN)          -
               v(xq)*sin((2*pi*50*($abstime) + v(teta))*TETA_GAIN)          +
	       v(x0));

v(xb) <+ GAIN*(v(xd)*cos((2*pi*50*($abstime) + v(teta))*TETA_GAIN - 2*pi/3) -
	       v(xq)*sin((2*pi*50*($abstime) + v(teta))*TETA_GAIN - 2*pi/3) +
	       v(x0));

v(xc) <+ GAIN*(v(xd)*cos((2*pi*50*($abstime) + v(teta))*TETA_GAIN + 2*pi/3) -
	       v(xq)*sin((2*pi*50*($abstime) + v(teta))*TETA_GAIN + 2*pi/3) +
	       v(x0));

end

endmodule
